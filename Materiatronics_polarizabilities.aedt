# Ansys Electronics Desktop project, version 2017.2
materials:
  vacuum: permittivity=1
  copper: permeability=0.999991 conductivity=58000000
  pec: conductivity=1e+030

design HFSSDesign1 (HFSS, DrivenModal, model units mm)
variables:
  box_x = lambda/2
  box_y = lambda/2
  box_z = lambda/2
  ex_hy = 1
  ex_nhy = 0
  ey_hx = 0
  ey_nhx = 0
  ex_hz = 0
  ex_nhz = 0
  ez_hx = 0
  ez_nhx = 0
  ey_hz = 0
  ey_nhz = 0
  ez_hy = 0
  ez_nhy = 0
  EX = ex_hy+ex_nhy+ex_hz+ex_nhz
  EY = ey_hx+ey_nhx+ey_hz+ey_nhz
  EZ = ez_hx+ez_nhx+ez_hy+ez_nhy
  KX = ey_hz-ey_nhz-ez_hy+ez_nhy
  KY = -ex_hz+ex_nhz+ez_hx-ez_nhx
  KZ = ex_hy-ex_nhy-ey_hx+ey_nhx
  lambda = 3*10^8/min_freq
  min_freq = 1.37GHz
geometry:
  Box1 [vacuum] = box(corner=(-box_x/2, -box_y/2, -box_z/2), size=(box_x, box_y, box_z))
boundaries and excitations:
  Rad1: Radiation Objects=Box1
  incident_waves: Plane Incident Wave IsCartesian EoX=EX EoY=EY EoZ=EZ kX=KX kY=KY kZ=KZ OriginX=0mm OriginY=0mm OriginZ=0mm IsPropagating
setups:
  Setup1: HfssDriven Frequency=1.43GHz MaxDeltaE=0.02 MaximumPasses=13 MinimumPasses=3 MinimumConvergedPasses=2 PercentRefinement=10 BasisOrder=1 RayDensityPerWavelength=4 MaxNumberOfBounces=5
    sweep Sweep: 1.37GHz to 1.43GHz, 21 points; Type=Discrete SaveFields
source amplitudes:
  incident_waves:1: 1 0deg
optimetrics:
  ParametricSetup1: Parametric Sim._Setups=[Setup1]
    sweep ex_hy: 0
    sweep ex_nhy: 0
    sweep ey_hx: 0
    sweep ey_nhx: 0
    sweep ex_hz: 0
    sweep ex_nhz: 0
    sweep ez_hx: 0
    sweep ez_nhx: 0
    sweep ey_hz: 0
    sweep ey_nhz: 0
    sweep ez_hy: 0
    sweep ez_nhy: 0
    table edits: add(0, 0, 0, 0, 0, 0, 0, 0, 0, 0, 0, 0) add(0, 0, 0, 0, 0, 0, 0, 0, 0, 0, 0, 0) add(0, 0, 0, 0, 0, 0, 0, 0, 0, 0, 0, 0) add(0, 0, 0, 0, 0, 0, 0, 0, 0, 0, 0, 0) add(0, 0, 0, 0, 0, 0, 0, 0, 0, 0, 0, 0) add(0, 0, 0, 0, 0, 0, 0, 0, 0, 0, 0, 0) add(0, 0, 0, 0, 0, 0, 0, 0, 0, 0, 0, 0) add(0, 0, 0, 0, 0, 0, 0, 0, 0, 0, 0, 0) add(0, 0, 0, 0, 0, 0, 0, 0, 0, 0, 0, 0) add(0, 0, 0, 0, 0, 0, 0, 0, 0, 0, 0, 0) add(0, 0, 0, 0, 0, 0, 0, 0, 0, 0, 0, 0) edit(0, 0, 0, 0, 0, 0, 0, 0, 0, 0, 0, 0, 1, 0, 0, 0, 0, 0, 0, 0, 0, 0, 0, 0) edit(0, 0, 0, 0, 0, 0, 0, 0, 0, 0, 0, 0, 0, 0, 0, 0, 1, 0, 0, 0, 0, 0, 0, 0) edit(0, 0, 0, 0, 0, 0, 0, 0, 0, 0, 0, 0, 0, 1, 0, 0, 0, 0, 0, 0, 0, 0, 0, 0) edit(0, 0, 0, 0, 0, 0, 0, 0, 0, 0, 0, 0, 0, 0, 0, 0, 0, 1, 0, 0, 0, 0, 0, 0) edit(0, 0, 0, 0, 0, 0, 0, 0, 0, 0, 0, 0, 0, 0, 1, 0, 0, 0, 0, 0, 0, 0, 0, 0) edit(0, 0, 0, 0, 0, 0, 0, 0, 0, 0, 0, 0, 0, 0, 0, 0, 0, 0, 0, 0, 1, 0, 0, 0) edit(0, 0, 0, 0, 0, 0, 0, 0, 0, 0, 0, 0, 0, 0, 0, 1, 0, 0, 0, 0, 0, 0, 0, 0) edit(0, 0, 0, 0, 0, 0, 0, 0, 0, 0, 0, 0, 0, 0, 0, 0, 0, 0, 0, 0, 0, 1, 0, 0) edit(0, 0, 0, 0, 0, 0, 0, 0, 0, 0, 0, 0, 0, 0, 0, 0, 0, 0, 1, 0, 0, 0, 0, 0) edit(0, 0, 0, 0, 0, 0, 0, 0, 0, 0, 0, 0, 0, 0, 0, 0, 0, 0, 0, 0, 0, 0, 1, 0) edit(0, 0, 0, 0, 0, 0, 0, 0, 0, 0, 0, 0, 0, 0, 0, 0, 0, 0, 0, 1, 0, 0, 0, 0) edit(0, 0, 0, 0, 0, 0, 0, 0, 0, 0, 0, 0, 0, 0, 0, 0, 0, 0, 0, 0, 0, 0, 0, 1)
radiation setups:
  minus_z: Infinite Sphere Theta=180deg..180deg step 1deg Phi=0deg..0deg step 1deg
  plus_z: Infinite Sphere Theta=0deg..0deg step 1deg Phi=0deg..0deg step 1deg
  minus_x: Infinite Sphere Theta=90deg..90deg step 1deg Phi=180deg..180deg step 1deg
  plus_x: Infinite Sphere Theta=90deg..90deg step 1deg Phi=0deg..0deg step 1deg
  minus_y: Infinite Sphere Theta=90deg..90deg step 1deg Phi=270deg..270deg step 1deg
  plus_y: Infinite Sphere Theta=90deg..90deg step 1deg Phi=90deg..90deg step 1deg
field plots:
  Mesh1: MeshPlots in Box1 on Setup1 : LastAdaptive at Freq=1.43GHz Phase=0deg
reports:
  all_polarizabilities: re(rEX), im(rEX), re(rEY), im(rEY) vs Freq on Setup1 : Sweep, plus_z [Phi=all Theta=all ex_hy=1 ex_nhy=0 ey_hx=0 ey_nhx=0 ex_hz=0 ex_nhz=0 ez_hx=0 ez_nhx=0 ey_hz=0 ey_nhz=0 ez_hy=0 ez_nhy=0]; re(rEX), im(rEX), re(rEY), im(rEY) vs Freq on Setup1 : Sweep, minus_z [Phi=all Theta=all ex_hy=1 ex_nhy=0 ey_hx=0 ey_nhx=0 ex_hz=0 ex_nhz=0 ez_hx=0 ez_nhx=0 ey_hz=0 ey_nhz=0 ez_hy=0 ez_nhy=0]; re(rEX), im(rEX), re(rEY), im(rEY) vs Freq on Setup1 : Sweep, plus_z [Phi=all Theta=all ex_hy=0 ex_nhy=1 ey_hx=0 ey_nhx=0 ex_hz=0 ex_nhz=0 ez_hx=0 ez_nhx=0 ey_hz=0 ey_nhz=0 ez_hy=0 ez_nhy=0]; re(rEX), im(rEX), re(rEY), im(rEY) vs Freq on Setup1 : Sweep, minus_z [Phi=all Theta=all ex_hy=0 ex_nhy=1 ey_hx=0 ey_nhx=0 ex_hz=0 ex_nhz=0 ez_hx=0 ez_nhx=0 ey_hz=0 ey_nhz=0 ez_hy=0 ez_nhy=0]; re(rEX), im(rEX), re(rEY), im(rEY) vs Freq on Setup1 : Sweep, plus_z [Phi=all Theta=all ex_hy=0 ex_nhy=0 ey_hx=1 ey_nhx=0 ex_hz=0 ex_nhz=0 ez_hx=0 ez_nhx=0 ey_hz=0 ey_nhz=0 ez_hy=0 ez_nhy=0]; re(rEX), im(rEX), re(rEY), im(rEY) vs Freq on Setup1 : Sweep, minus_z [Phi=all Theta=all ex_hy=0 ex_nhy=0 ey_hx=1 ey_nhx=0 ex_hz=0 ex_nhz=0 ez_hx=0 ez_nhx=0 ey_hz=0 ey_nhz=0 ez_hy=0 ez_nhy=0]; re(rEX), im(rEX), re(rEY), im(rEY) vs Freq on Setup1 : Sweep, plus_z [Phi=all Theta=all ex_hy=0 ex_nhy=0 ey_hx=0 ey_nhx=1 ex_hz=0 ex_nhz=0 ez_hx=0 ez_nhx=0 ey_hz=0 ey_nhz=0 ez_hy=0 ez_nhy=0]; re(rEX), im(rEX), re(rEY), im(rEY) vs Freq on Setup1 : Sweep, minus_z [Phi=all Theta=all ex_hy=0 ex_nhy=0 ey_hx=0 ey_nhx=1 ex_hz=0 ex_nhz=0 ez_hx=0 ez_nhx=0 ey_hz=0 ey_nhz=0 ez_hy=0 ez_nhy=0]; re(rEX), im(rEX), re(rEZ), im(rEZ) vs Freq on Setup1 : Sweep, plus_y [Phi=all Theta=all ex_hy=0 ex_nhy=0 ey_hx=0 ey_nhx=0 ex_hz=1 ex_nhz=0 ez_hx=0 ez_nhx=0 ey_hz=0 ey_nhz=0 ez_hy=0 ez_nhy=0]; re(rEX), im(rEX), re(rEZ), im(rEZ) vs Freq on Setup1 : Sweep, minus_y [Phi=all Theta=all ex_hy=0 ex_nhy=0 ey_hx=0 ey_nhx=0 ex_hz=1 ex_nhz=0 ez_hx=0 ez_nhx=0 ey_hz=0 ey_nhz=0 ez_hy=0 ez_nhy=0]; re(rEX), im(rEX), re(rEZ), im(rEZ) vs Freq on Setup1 : Sweep, plus_y [Phi=all Theta=all ex_hy=0 ex_nhy=0 ey_hx=0 ey_nhx=0 ex_hz=0 ex_nhz=1 ez_hx=0 ez_nhx=0 ey_hz=0 ey_nhz=0 ez_hy=0 ez_nhy=0]; re(rEX), im(rEX), re(rEZ), im(rEZ) vs Freq on Setup1 : Sweep, minus_y [Phi=all Theta=all ex_hy=0 ex_nhy=0 ey_hx=0 ey_nhx=0 ex_hz=0 ex_nhz=1 ez_hx=0 ez_nhx=0 ey_hz=0 ey_nhz=0 ez_hy=0 ez_nhy=0]; re(rEX), im(rEX), re(rEZ), im(rEZ) vs Freq on Setup1 : Sweep, plus_y [Phi=all Theta=all ex_hy=0 ex_nhy=0 ey_hx=0 ey_nhx=0 ex_hz=0 ex_nhz=0 ez_hx=1 ez_nhx=0 ey_hz=0 ey_nhz=0 ez_hy=0 ez_nhy=0]; re(rEX), im(rEX), re(rEZ), im(rEZ) vs Freq on Setup1 : Sweep, minus_y [Phi=all Theta=all ex_hy=0 ex_nhy=0 ey_hx=0 ey_nhx=0 ex_hz=0 ex_nhz=0 ez_hx=1 ez_nhx=0 ey_hz=0 ey_nhz=0 ez_hy=0 ez_nhy=0]; re(rEX), im(rEX), re(rEZ), im(rEZ) vs Freq on Setup1 : Sweep, plus_y [Phi=all Theta=all ex_hy=0 ex_nhy=0 ey_hx=0 ey_nhx=0 ex_hz=0 ex_nhz=0 ez_hx=0 ez_nhx=1 ey_hz=0 ey_nhz=0 ez_hy=0 ez_nhy=0]; re(rEX), im(rEX), re(rEZ), im(rEZ) vs Freq on Setup1 : Sweep, minus_y [Phi=all Theta=all ex_hy=0 ex_nhy=0 ey_hx=0 ey_nhx=0 ex_hz=0 ex_nhz=0 ez_hx=0 ez_nhx=1 ey_hz=0 ey_nhz=0 ez_hy=0 ez_nhy=0]; re(rEY), im(rEY), re(rEZ), im(rEZ) vs Freq on Setup1 : Sweep, plus_x [Phi=all Theta=all ex_hy=0 ex_nhy=0 ey_hx=0 ey_nhx=0 ex_hz=0 ex_nhz=0 ez_hx=0 ez_nhx=0 ey_hz=1 ey_nhz=0 ez_hy=0 ez_nhy=0]; re(rEY), im(rEY), re(rEZ), im(rEZ) vs Freq on Setup1 : Sweep, minus_x [Phi=all Theta=all ex_hy=0 ex_nhy=0 ey_hx=0 ey_nhx=0 ex_hz=0 ex_nhz=0 ez_hx=0 ez_nhx=0 ey_hz=1 ey_nhz=0 ez_hy=0 ez_nhy=0]; re(rEY), im(rEY), re(rEZ), im(rEZ) vs Freq on Setup1 : Sweep, plus_x [Phi=all Theta=all ex_hy=0 ex_nhy=0 ey_hx=0 ey_nhx=0 ex_hz=0 ex_nhz=0 ez_hx=0 ez_nhx=0 ey_hz=0 ey_nhz=1 ez_hy=0 ez_nhy=0]; re(rEY), im(rEY), re(rEZ), im(rEZ) vs Freq on Setup1 : Sweep, minus_x [Phi=all Theta=all ex_hy=0 ex_nhy=0 ey_hx=0 ey_nhx=0 ex_hz=0 ex_nhz=0 ez_hx=0 ez_nhx=0 ey_hz=0 ey_nhz=1 ez_hy=0 ez_nhy=0]
